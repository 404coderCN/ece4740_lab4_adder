// VerilogA for ece4740, lab2_signal_gen, veriloga

`include "constants.vams"
`include "disciplines.vams"

module lab2_signal_gen(A,B);

output [15:0] A;
output [15:0] B;

voltage [15:0] A;
voltage [15:0] B;

integer			Aresult, Bresult, count;
parameter real	clk_period = 1000p from (0:inf);
parameter real	clk_period2 = 500p from (0:inf);
parameter real	clk_high = 1.2;
parameter real	clk_low = 0.0;
parameter real	trise = 20p from [0:inf];
parameter real	tfall = 20p from [0:inf];
genvar i;

analog begin

	@(initial_step) begin
	 Aresult = 0;
	 Bresult = 0;
	 count = 0;
	end

	@(timer(0n,clk_period2)) begin
		if (count==0) begin
			Aresult = 1;
			Bresult = 2;
		end
		else if (count==1) begin
			Aresult = 420;
			Bresult = 69;
		end
		count = count + 1;
	end

	for (i=0; i<16; i=i+1) begin
		V(A[i])	 <+ transition(Aresult & (1<<i) ? clk_high : clk_low, 0, trise, tfall);
		V(B[i])	 <+ transition(Bresult & (1<<i) ? clk_high : clk_low, 0, trise, tfall);
	end

end

endmodule
